// I3C controller register map based on MIPI HCI 1.2

`include "secure_firmware_recovery_interface.rdl"
`include "target_transaction_interface.rdl"
`include "soc_management_interface.rdl"
`include "controller_config.rdl"
`include "standby_controller_mode.rdl"
`include "../i3c_defines.svh"

regfile ECRegisters #(
    bit tti_rx_desc_fifo_size = 0x5, // 64 DWORDs by default
    bit tti_tx_desc_fifo_size = 0x5, // 64 DWORDs by default
    bit tti_rx_fifo_size = 0x5, // 64 DWORDs by default
    bit tti_tx_fifo_size = 0x5, // 64 DWORDs by default
    bit tti_ibi_fifo_size = 0x5, // 64 DWORDs by default
    bit pid_hi = 0x0,
    bit pid_lo = 0x0,
    bit virtual_pid_hi = 0x0,
    bit virtual_pid_lo = 0x0
){
    name = "Extended Capabilities";
`ifdef TARGET_SUPPORT
    SecureFirmwareRecoveryInterfaceRegisters SecFwRecoveryIf @ 0x0;
`endif
    StandbyControllerModeRegisters #(
        .pid_hi(pid_hi),
        .pid_lo(pid_lo),
        .virtual_pid_hi(virtual_pid_hi),
        .virtual_pid_lo(virtual_pid_lo)
    ) StdbyCtrlMode;
`ifdef TARGET_SUPPORT
    TargetTransactionInterfaceRegisters #(
        .rx_desc_fifo_size(tti_rx_desc_fifo_size),
        .tx_desc_fifo_size(tti_tx_desc_fifo_size),
        .rx_fifo_size(tti_rx_fifo_size),
        .tx_fifo_size(tti_tx_fifo_size),
        .ibi_fifo_size(tti_ibi_fifo_size)
    ) TTI;
`endif
    SoCManagementInterfaceRegisters SoCMgmtIf;
    ControllerConfigRegisters CtrlCfg;
    reg {
        desc = "Register after the last EC must advertise ID == 0.
        Termination register is added to guarantee that the discovery mechanism
        reaches termination value.
        ";
        regwidth = 32;
        field {
            name = "CAP_LENGTH";
            desc = "Capability Structure Length in DWORDs";
            sw = r;
            hw = r;
            reset = 16'h0001;
        } CAP_LENGTH[23:8];
        field {
            name = "CAP_ID";
            desc = "Extended Capability ID";
            sw = r;
            hw = r;
            reset = 8'h00;
        } CAP_ID[7:0];
    } TERMINATION_EXTCAP_HEADER;
};
