// I3C controller register map based on MIPI HCI 1.2


regfile SecureFirmwareRecoveryInterfaceRegisters{
    name = "Secure Firmware Recovery Interface";
    default regwidth = 32;
    reg {
        regwidth = 32;
        field {
            name = "CAP_LENGTH";
            desc = "Capability Structure Length in DWORDs";
            sw = r;
            hw = r;
            reset = 16'h0020;
        } CAP_LENGTH[23:8];
        field {
            name = "CAP_ID";
            desc = "Extended Capability ID";
            sw = r;
            hw = r;
            reset = 8'hC0;
        } CAP_ID[7:0];
    } EXTCAP_HEADER;
    reg {
        name = "Recovery Protocol Capabilities 0";
        field {
            name = "Recovery protocol magic string";
            desc = "Magic string 'OCP ' (1st part of 'OCP RECV') in ASCII code - '0x4f 0x43 0x50 0x20'";
            sw = r;
            hw = r;
            reset = 32'h2050434f;
        } REC_MAGIC_STRING_0[31:0];
    } PROT_CAP_0;
    reg {
        name = "Recovery Protocol Capabilities 1";
        field {
            name = "Recovery protocol magic string";
            desc = "Magic string 'RECV' (2nd part of 'OCP RECV') in ASCII code - '0x52 0x45 0x43 0x56'";
            sw = r;
            hw = r;
            reset = 32'h56434552;
        } REC_MAGIC_STRING_1[31:0];
    } PROT_CAP_1;
    reg {
        name = "Recovery Protocol Capabilities 2";
        field {
            name = "Recovery protocol version";
            desc = "* Byte 0: Major version number = 0x1

                    * Byte 1: Minor version number = 0x1";
            sw = rw;
            hw = rw;
            we = true;
            reset = 16'h0;
        } REC_PROT_VERSION[15:0];
        field {
            name = "Recovery protocol capabilities";
            desc = "Agent capabilities:

                    * bit 0: Identification (DEVICE_ID structure)

                    * bit 1: Forced Recovery (From RESET)

                    * bit 2: Mgmt reset (From RESET)

                    * bit 3: Device Reset (From RESET)

                    * bit 4: Device status (DEVICE_STATUS)

                    * bit 5: Recovery memory access (INDIRECT_CTRL)

                    * bit 6: Local C-image support

                    * bit 7: Push C-image support

                    * bit 8: Interface isolation

                    * bit 9: Hardware status

                    * bit 10: Vendor command

                    * bit 11: Flashless boot (From RESET)

                    * bit 12: FIFO CMS support (INDIRECT_FIFO_CTRL)

                    * bits 13-15: Reserved";
            sw = rw;
            hw = rw;
            we = true;
            reset = 16'h0;
        } AGENT_CAPS[31:16];
    } PROT_CAP_2;
    reg {
        name = "Recovery Protocol Capabilities 3";
        field {
            name = "Total number of CMS regions";
            desc = "0-255: The total number of component memory space (CMS) regions a device supports. This number includes any logging, code and vendor defined regions";
            sw = rw;
            hw = rw;
            we = true;
            reset = 8'h0;
        } NUM_OF_CMS_REGIONS[7:0];
        field {
            name = "Maximum Response Time";
            desc = "0-255: Maximum response time in 2^x microseconds(us).";
            sw = rw;
            hw = rw;
            we = true;
            reset = 8'h0;
        } MAX_RESP_TIME[15:8];
        field {
            name = "Heartbeat Period";
            desc = "0-255: Heartbeat period, 2^x microseconds (us), 0 indicates not supported";
            sw = rw;
            hw = rw;
            we = true;
            reset = 8'h0;
        } HEARTBEAT_PERIOD[23:16];
    } PROT_CAP_3;
    reg {
        name = "Device Identification 0";
        field {
            name = "Initial descriptor type";
            desc = "Based on table 8 from [DMTF PLDM FM]:

                    * 0x00: PCI Vendor

                    * 0x1: IANA

                    * 0x2: UUID

                    * 0x3: PnP Vendor

                    * 0x4: ACPI Vendor

                    * 0x5: IANA Enterprise Type

                    * 0x6-0xFE: Reserved

                    * 0xFF: NVMe-MI";
            sw = rw;
            hw = rw;
            we = true;
            reset = 8'h0;
        } DESC_TYPE[7:0];
        field {
            name = "Vendor Specific String Length";
            desc = "0x0-0xFF: Total length of Vendor Specific String, 0 indicates not supported";
            sw = rw;
            hw = rw;
            we = true;
            reset = 8'h0;
        } VENDOR_SPECIFIC_STR_LENGTH[15:8];
        field {
            name = "";
            desc = "";
            sw = rw;
            hw = rw;
            we = true;
            reset = 16'h0;
        } DATA[31:16];
    } DEVICE_ID_0;
    reg {
        name = "Device Identification 1";
        field {
            name = "";
            desc = "";
            sw = rw;
            hw = rw;
            we = true;
            reset = 32'h0;
        } DATA[31:0];
    } DEVICE_ID_1;
    reg {
        name = "Device Identification 2";
        field {
            name = "";
            desc = "";
            sw = rw;
            hw = rw;
            we = true;
            reset = 32'h0;
        } DATA[31:0];
    } DEVICE_ID_2;
    reg {
        name = "Device Identification 3";
        field {
            name = "";
            desc = "";
            sw = rw;
            hw = rw;
            we = true;
            reset = 32'h0;
        } DATA[31:0];
    } DEVICE_ID_3;
    reg {
        name = "Device Identification 4";
        field {
            name = "";
            desc = "";
            sw = rw;
            hw = rw;
            we = true;
            reset = 32'h0;
        } DATA[31:0];
    } DEVICE_ID_4;
    reg {
        name = "Device Identification 5";
        field {
            name = "";
            desc = "";
            sw = rw;
            hw = rw;
            we = true;
            reset = 32'h0;
        } DATA[31:0];
    } DEVICE_ID_5;
    reg {
        name = "Reserved";
        field {
            name = "";
            desc = "";
            sw = r;
            hw = r;
            reset = 32'h0;
        } DATA[31:0];
    } DEVICE_ID_RESERVED;
    reg {
        name = "Device status 0";
        field {
            name = "Device status";
            desc = "* 0x0: Status Pending (Recover Reason Code not populated)

                    * 0x1: Device healthy (Recover Reason Code not populated)

                    * 0x2: Device Error (“soft” error or other error state) - (Recover Reason Code not populated)

                    * 0x3: Recovery mode - ready to accept recovery image - (Recover Reason Code populated)

                    * 0x4: Recovery Pending (waiting for activation) - (Recover Reason Code populated)

                    * 0x5: Running Recovery Image ( Recover Reason Code not populated)

                    * 0x6-0xD: Reserved

                    * 0xE: Boot Failure (Recover Reason Code populated)

                    * 0xF: Fatal Error (Recover Reason Code not populated)

                    * 0x10-FF:Reserved";
            sw = rw;
            hw = rw;
            we = true;
            reset = 8'h0;
        } DEV_STATUS[7:0];
        field {
            name = "Protocol Error";
            desc = "* 0x0: No Protocol Error

                    * 0x1: Unsupported/Write Command - command is not support or a write to a RO command

                    * 0x2: Unsupported Parameter

                    * 0x3: Length write error (length of write command is incorrect)

                    * 0x4: CRC Error (if supported)

                    * 0x5-0xFE: Reserved

                    * 0xFF: General Protocol Error - catch all unclassified errors";
            sw = rw;
            hw = rw;
            we = true;
            onread = rclr;
            reset = 8'h0;
        } PROT_ERROR[15:8];
        field {
            name = "Recovery Reason Codes";
            desc = "* 0x0: No Boot Failure detected (BFNF)

                    * 0x1: Generic hardware error (BFGHWE)

                    * 0x2: Generic hardware soft error (BFGSE) - soft error may be recoverable

                    * 0x3: Self-test failure (BFSTF) (e.g., RSA self test failure, FIPs self test failure,, etc.)

                    * 0x4: Corrupted/missing critical data (BFCD)

                    * 0x5: Missing/corrupt key manifest (BFKMMC)

                    * 0x6: Authentication Failure on key manifest (BFKMAF)

                    * 0x7: Anti-rollback failure on key manifest (BFKIAR)

                    * 0x8: Missing/corrupt boot loader (first mutable code) firmware image (BFFIMC)

                    * 0x9: Authentication failure on boot loader ( 1st mutable code) firmware image (BFFIAF)

                    * 0xA: Anti-rollback failure boot loader (1st mutable code) firmware image (BFFIAR)

                    * 0xB: Missing/corrupt main/management firmware image (BFMFMC)

                    * 0xC: Authentication Failure main/management firmware image (BFMFAF)

                    * 0xD: Anti-rollback Failure main/management firmware image (BFMFAR)

                    * 0xE: Missing/corrupt recovery firmware (BFRFMC)

                    * 0xF: Authentication Failure recovery firmware (BFRFAF)

                    * 0x10: Anti-rollback Failure on recovery firmware (BFRFAR)

                    * 0x11: Forced Recovery (FR)

                    * 0x12: Flashless/Streaming Boot (FSB)

                    * 0x13-0x7F: Reserved

                    * 0x80-0xFF: Vendor Unique Boot Failure Codes";
            sw = rw;
            hw = rw;
            we = true;
            reset = 16'h0;
        } REC_REASON_CODE[31:16];
    } DEVICE_STATUS_0;
    reg {
        name = "Device status 1";
        field {
            name = "Heartbeat";
            desc = "0-4095: Incrementing number (counter wraps)";
            sw = rw;
            hw = rw;
            we = true;
            reset = 16'h0;
        } HEARTBEAT[15:0];
        field {
            name = "Vendor Status Length";
            desc = "0-248: Length in bytes of just VENDOR_STATUS. Zero indicates no vendor status and zero additional bytes.";
            sw = rw;
            hw = rw;
            we = true;
            reset = 8'h0;
        } VENDOR_STATUS_LENGTH[24:16];
        field {
            name = "Vendor defined status message";
            sw = rw;
            hw = rw;
            we = true;
            reset = 8'h0;
        } VENDOR_STATUS[31:25];
    } DEVICE_STATUS_1;
    reg {
        name = "Reset control";
        desc = "For devices which support reset, this register will reset the device or management entity";
        field {
            name = "Device Reset Control";
            desc = "* 0x0: No reset

                    * 0x1: Reset Device (PCIe Fundamental Reset or equivalent. This is likely bus disruptive)

                    * 0x2: Reset Management. This reset will reset the management subsystem. If supported, this reset MUST not be bus disruptive (cause re-enumeration)

                    * 0x3-FF: Reserved";
            sw = rw;
            hw = rw;
            we = true;
            onwrite = woclr;
            reset = 8'h0;
        } RESET_CTRL[7:0];
        field {
            name = "Forced Recovery";
            desc = "* 0x0: No forced recovery

                    * 0x01-0xD: Reserved

                    * 0xE: Enter flashless boot mode on next platform reset

                    * 0xF: Enter recovery mode on next platform reset

                    * 0x10-FF: Reserved";
            sw = rw;
            hw = rw;
            we = true;
            reset = 8'h0;
        } FORCED_RECOVERY[15:8];
        field {
            name = "Interface Control";
            desc = "* 0x0: Disable Interface mastering

                    * 0x1: Enable Interface mastering";
            sw = rw;
            hw = rw;
            we = true;
            reset = 8'h0;
        } IF_CTRL[23:16];
    } DEVICE_RESET;
    reg {
        name = "Recovery configuration/control";
        field {
            name = "Component Memory Space (CMS)";
            desc = "* 0-255: Selects a component memory space where the recovery image is. 0 is the default";
            sw = rw;
            hw = rw;
            we = true;
            reset = 8'h0;
            swmod = true;
        } CMS[7:0];
        field {
            name = "Recovery Image Selection";
            desc = "* 0x0: No operation

                    * 0x1: Use Recovery Image from memory window (CMS)

                    * 0x2: Use Recovery Image stored on device (C-image)

                    * 0x3-FF: reserved";
            sw = rw;
            hw = rw;
            we = true;
            reset = 8'h0;
            swmod = true;
        } REC_IMG_SEL[15:8];
        field {
            name = "Activate Recovery Image";
            desc = "* 0x0: do not activate recovery image - after activation device will report this code.

                    * 0xF: Activate recovery image

                    * 0x10-FF-reserved";
            sw = rw;
            hw = rw;
            we = true;
            reset = 8'h0;
            onwrite = woclr;
            swmod = true;
        } ACTIVATE_REC_IMG[23:16];
    } RECOVERY_CTRL;
    reg {
        name = "Recovery status";
        field {
            name = "Device recovery status";
            desc = "* 0x0: Not in recovery mode

                    * 0x1: Awaiting recovery image

                    * 0x2: Booting recovery image

                    * 0x3: Recovery successful

                    * 0xc: Recovery failed

                    * 0xd: Recovery image authentication error

                    * 0xe: Error entering Recovery mode (might be administratively disabled)

                    * 0xf: Invalid component address space";
            sw = rw;
            hw = rw;
            we = true;
            reset = 4'h0;
        } DEV_REC_STATUS[3:0];
        field {
            name = "Recovery image index";
            sw = rw;
            hw = rw;
            we = true;
            reset = 32'h0;
        } REC_IMG_INDEX[7:4];
        field {
            name = "Vendor specific status";
            sw = rw;
            hw = rw;
            we = true;
            reset = 8'h0;
        } VENDOR_SPECIFIC_STATUS[15:8];
    } RECOVERY_STATUS;
    reg {
        name = "Hardware status";
        field {
            name = "Device temperature critical";
            desc = "Device temperature is critical (may need reset to clear)";
            sw = rw;
            hw = rw;
            we = true;
            reset = 1'h0;
        } TEMP_CRITICAL[0:0];
        field {
            name = "Hardware Soft Error";
            desc = "Hardware Soft Error (may need reset to clear)";
            sw = rw;
            hw = rw;
            we = true;
            reset = 1'h0;
        } SOFT_ERR[1:1];
        field {
            name = "Hardware Fatal Error";
            sw = rw;
            hw = rw;
            we = true;
            reset = 1'h0;
        } FATAL_ERR[2:2];
        field {
            name = "Reserved";
            sw = rw;
            hw = rw;
            we = true;
            reset = 5'h0;
        } RESERVED_7_3[7:3];
        field {
            name = "Vendor HW Status (bit mask active high)";
            sw = rw;
            hw = rw;
            we = true;
            reset = 8'h0;
        } VENDOR_HW_STATUS[15:8];
        field {
            name = "Composite temperature (CTemp)";
            desc = "Current temperatureof device in degrees Celsius: Compatible with NVMe-MI command code 0 offset 3.

                    * 0x00-0x7e: 0 to 126 C

                    * 0x7f: 127 C or higher

                    * 0x80: no temperature data, or data is older than 5 seconds

                    * 0x81: temperature sensor failure

                    * 0x82-0x83: reserved

                    * 0xc4: -60 C or lower

                    * 0xc5-0xff: -59 to -1 C (in two's complement)";
            sw = rw;
            hw = rw;
            we = true;
            reset = 8'h0;
        } CTEMP[23:16];
        field {
            name = "Vendor Specific Hardware Status length (bytes)";
            desc = "0-251: Length in bytes of Vendor Specific Hardware Status.";
            sw = rw;
            hw = rw;
            we = true;
            reset = 8'h0;
        } VENDOR_HW_STATUS_LEN[31:24];
    } HW_STATUS;
    reg {
        name = "Indirect FIFO Control 0";
        field {
            name = "Indirect FIFO memory access configuration.";
            desc = "This register selects a region within the device. Read/write access is through address
                    spaces. Each space represents a FIFO.
                    Component Memory Space (CMS):

                    * 0-255: Address region within a device.";
            sw = rw;
            hw = rw;
            we = true;
            reset = 8'h00;
        } CMS[7:0];
        field {
            name = "Indirect memory configuration - reset";
            desc = "Reset (Write 1 Clear):

                    * 0x0: idle

                    * 0x1: reset Write Index and Read Index to initial value.

                    * 0x2 to 0xFF: reserved";
            sw = rw;
            hw = rw;
            we = true;
            onwrite = woclr;
            reset = 8'h00;
        } RESET[15:8];
    } INDIRECT_FIFO_CTRL_0;
    reg {
        name = "Indirect FIFO Control 1";
        field {
            name = "Indirect memory configuration - Image Size";
            desc = "Image Size: Size of the image to be loaded in 4B units";
            sw = rw;
            hw = rw;
            we = true;
            reset = 32'h0;
        } IMAGE_SIZE[31:0];
    } INDIRECT_FIFO_CTRL_1;
    reg {
        name = "Indirect FIFO Status 0";
        field {
            name = "FIFO Empty";
            desc = "If set, FIFO is empty";
            sw = r;
            hw = rw;
            we = true;
            reset = 1'h1;
        } EMPTY[0:0];
        field {
            name = "FIFO Full";
            desc = "If set, FIFO is full";
            sw = r;
            hw = rw;
            we = true;
            reset = 1'h0;
        } FULL[1:1];
        field {
            name = "Memory Region Type";
            desc = "Memory Region Type:

                    * 0b000: Code space for recovery. (write only)

                    * 0b001: Log uses the defined debug format (read only)

                    * 0b100: Vendor Defined Region (write only)

                    * 0b101: Vendor Defined Region (read only)

                    * 0b111: Unsupported Region (address space out of range)";
            sw = r;
            hw = rw;
            we = true;
            reset = 3'h0;
        } REGION_TYPE[10:8];
    } INDIRECT_FIFO_STATUS_0;
    reg {
        name = "Indirect FIFO Status 1";
        field {
            name = "FIFO Write Index";
            desc = "Offset incremented for each access by the Recovery Agent in 4B units";
            sw = r;
            hw = rw;
            we = true;
            reset = 32'h0;
        } WRITE_INDEX[31:0];
    } INDIRECT_FIFO_STATUS_1;
    reg {
        name = "Indirect FIFO Status 2";
        field {
            name = "FIFO Read Index";
            desc = "Offset incremented for each access by the device in 4B units";
            sw = r;
            hw = rw;
            we = true;
            reset = 32'h0;
        } READ_INDEX[31:0];
    } INDIRECT_FIFO_STATUS_2;
    reg {
        name = "Indirect FIFO Status 3";
        field {
            name = "Indirect FIFO size";
            desc = "Size of memory window specified in 4B units";
            sw = r;
            hw = rw;
            we = true;
            reset = 32'h0;
        } FIFO_SIZE[31:0];
    } INDIRECT_FIFO_STATUS_3;
    reg {
        name = "Indirect FIFO Status 4";
        field {
            name = "Max transfer size";
            desc = "Max size of the data payload in each read/write to INDIRECT_FIFO_DATA in 4B units";
            sw = r;
            hw = rw;
            we = true;
            reset = 32'h0;
        } MAX_TRANSFER_SIZE[31:0];
    } INDIRECT_FIFO_STATUS_4;
    reg {
        name = "INDIRECT_FIFO_RESERVED";
        field {
            name = "Reserved register";
            sw = r;
            hw = rw;
            we = true;
            reset = 32'h0;
        } DATA[31:0];
    } INDIRECT_FIFO_RESERVED;
    external reg {
        name = "INDIRECT_FIFO_DATA";
        desc = "Indirect memory access to address space configured in INDIRECT_FIFO_CTRL at the Head Pointer offset.";
        field {
            sw = rw;
            hw = rw;
            reset = 32'h0;
        } DATA[31:0];
    } INDIRECT_FIFO_DATA;
};
