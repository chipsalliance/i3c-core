// I3C controller register map based on MIPI HCI 1.2


regfile SoCManagementInterfaceRegisters{
    default regwidth = 32;
    reg {
        regwidth = 32;
        field {
            name = "CAP_LENGTH";
            desc = "Capability Structure Length in DWORDs";
            sw = r;
            hw = r;
            reset = 16'h0000;
        } CAP_LENGTH[23:8];
        field {
            name = "CAP_ID";
            desc = "Extended Capability ID";
            sw = r;
            hw = r;
            reset = 8'hC1;
        } CAP_ID[7:0];
    } EXTCAP_HEADER;
    reg {
        name = "SoC Management Control";
        field {
            name = "";
            desc = "";
            sw = rw;
            hw = rw;
            reset = 32'h00000000;
        } PLACEHOLDER[31:0];
    } SOC_MGMT_CONTROL;
    reg {
        name = "SoC Management Status";
        field {
            name = "";
            desc = "";
            sw = rw;
            hw = rw;
            reset = 32'h00000000;
        } PLACEHOLDER[31:0];
    } SOC_MGMT_STATUS;
    reg {
        name = "";
        field {
            name = "";
            desc = "";
            sw = rw;
            hw = rw;
            reset = 32'h00000000;
        } PLACEHOLDER[31:0];
    } SOC_MGMT_RSVD_0;
    reg {
        name = "";
        field {
            name = "";
            desc = "";
            sw = rw;
            hw = rw;
            reset = 32'h00000000;
        } PLACEHOLDER[31:0];
    } SOC_MGMT_RSVD_1;
    reg {
        name = "";
        field {
            name = "";
            desc = "";
            sw = rw;
            hw = rw;
            reset = 32'h00000000;
        } PLACEHOLDER[31:0];
    } SOC_MGMT_RSVD_2;
    reg {
        name = "";
        field {
            name = "";
            desc = "";
            sw = rw;
            hw = rw;
            reset = 32'h00000000;
        } PLACEHOLDER[31:0];
    } SOC_MGMT_RSVD_3;
    reg {
        name = "";
        field {
            name = "";
            desc = "";
            sw = rw;
            hw = rw;
            reset = 32'h00000000;
        } PLACEHOLDER[31:0];
    } SOC_MGMT_FEATURE_0;
    reg {
        name = "";
        field {
            name = "";
            desc = "";
            sw = rw;
            hw = rw;
            reset = 32'h00000000;
        } PLACEHOLDER[31:0];
    } SOC_MGMT_FEATURE_1;
    reg {
        name = "";
        field {
            name = "";
            desc = "";
            sw = rw;
            hw = rw;
            reset = 32'h00000000;
        } PLACEHOLDER[31:0];
    } SOC_MGMT_FEATURE_2;
    reg {
        name = "";
        field {
            name = "";
            desc = "";
            sw = rw;
            hw = rw;
            reset = 32'h00000000;
        } PLACEHOLDER[31:0];
    } SOC_MGMT_FEATURE_3;
    reg {
        name = "";
        field {
            name = "";
            desc = "";
            sw = rw;
            hw = rw;
            reset = 32'h00000000;
        } PLACEHOLDER[31:0];
    } SOC_MGMT_FEATURE_4;
    reg {
        name = "";
        field {
            name = "";
            desc = "";
            sw = rw;
            hw = rw;
            reset = 32'h00000000;
        } PLACEHOLDER[31:0];
    } SOC_MGMT_FEATURE_5;
    reg {
        name = "";
        field {
            name = "";
            desc = "";
            sw = rw;
            hw = rw;
            reset = 32'h00000000;
        } PLACEHOLDER[31:0];
    } SOC_MGMT_FEATURE_6;
    reg {
        name = "";
        field {
            name = "";
            desc = "";
            sw = rw;
            hw = rw;
            reset = 32'h00000000;
        } PLACEHOLDER[31:0];
    } SOC_MGMT_FEATURE_7;
    reg {
        name = "";
        field {
            name = "";
            desc = "";
            sw = rw;
            hw = rw;
            reset = 32'h00000000;
        } PLACEHOLDER[31:0];
    } SOC_MGMT_FEATURE_8;
    reg {
        name = "";
        field {
            name = "";
            desc = "";
            sw = rw;
            hw = rw;
            reset = 32'h00000000;
        } PLACEHOLDER[31:0];
    } SOC_MGMT_FEATURE_9;
    reg {
        name = "";
        field {
            name = "";
            desc = "";
            sw = rw;
            hw = rw;
            reset = 32'h00000000;
        } PLACEHOLDER[31:0];
    } SOC_MGMT_FEATURE_10;
    reg {
        name = "";
        field {
            name = "";
            desc = "";
            sw = rw;
            hw = rw;
            reset = 32'h00000000;
        } PLACEHOLDER[31:0];
    } SOC_MGMT_FEATURE_11;
    reg {
        name = "";
        field {
            name = "";
            desc = "";
            sw = rw;
            hw = rw;
            reset = 32'h00000000;
        } PLACEHOLDER[31:0];
    } SOC_MGMT_FEATURE_12;
    reg {
        name = "";
        field {
            name = "";
            desc = "";
            sw = rw;
            hw = rw;
            reset = 32'h00000000;
        } PLACEHOLDER[31:0];
    } SOC_MGMT_FEATURE_13;
    reg {
        name = "";
        field {
            name = "";
            desc = "";
            sw = rw;
            hw = rw;
            reset = 32'h00000000;
        } PLACEHOLDER[31:0];
    } SOC_MGMT_FEATURE_14;
    reg {
        name = "";
        field {
            name = "";
            desc = "";
            sw = rw;
            hw = rw;
            reset = 32'h00000000;
        } PLACEHOLDER[31:0];
    } SOC_MGMT_FEATURE_15;
};
