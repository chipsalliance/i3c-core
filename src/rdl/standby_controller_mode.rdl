// I3C controller register map based on MIPI HCI 1.2


regfile StandbyControllerModeRegisters{
    default regwidth = 32;
    reg {
        regwidth = 32;
        field {
            name = "CAP_LENGTH";
            desc = "Capability Structure Length in DWORDs";
            sw = r;
            hw = r;
            reset = 16'h0000;
        } CAP_LENGTH[23:8];
        field {
            name = "CAP_ID";
            desc = "Extended Capability ID";
            sw = r;
            hw = r;
            reset = 8'h12;
        } CAP_ID[7:0];
    } EXTCAP_HEADER;
    reg {
        name = "Standby Controller Control";
        desc = "";
        field {
            name = "Host Controller Secondary Controller Enable";
            desc = "";
            sw = rw;
            hw = rw;
            reset = 2'h0;
        } STBY_CR_ENABLE_INT[31:30];
        field {
            name = "RSTACT Support DefByte 0x02";
            desc = "";
            sw = rw;
            hw = rw;
            reset = 1'h0;
        } RSTACT_DEFBYTE_02[20:20];
        field {
            name = "Dynamic Address Method Enable ENTDAA";
            desc = "";
            sw = rw;
            hw = rw;
            reset = 1'h0;
        } DAA_ENTDAA_ENABLE[15:15];
        field {
            name = "Dynamic Address Method Enable SETDASA";
            desc = "";
            sw = rw;
            hw = rw;
            reset = 1'h0;
        } DAA_SETDASA_ENABLE[14:14];
        field {
            name = "Dynamic Address Method Enable SETAASA";
            desc = "";
            sw = rw;
            hw = rw;
            reset = 1'h0;
        } DAA_SETAASA_ENABLE[13:13];
        field {
            name = "Target Transaction Interface Servicing Enable";
            desc = "";
            sw = rw;
            hw = rw;
            reset = 1'h0;
        } TARGET_XACT_ENABLE[12:12];
        field {
            name = "Ring Bundle IBI Selector for Broadcast CCC Capture";
            desc = "";
            sw = rw;
            hw = rw;
            reset = 1'h0;
        } BAST_CCC_IBI_RING[10:8];
        field {
            name = "Send Controller Role Request";
            desc = "";
            sw = rw;
            hw = rw;
            reset = 1'h0;
        } CR_REQUEST_SEND[5:5];
        field {
            name = "Handoff Deep Sleep";
            desc = "";
            sw = rw;
            hw = rw;
            reset = 1'h0;
        } HANDOFF_DEEP_SLEEP[4:4];
        field {
            name = "Prime to Accept Controller Role";
            desc = "";
            hw   = rw;
            sw   = rw;
        } PRIME_ACCEPT_GETACCCR[3:3];
        field {
            name = "Active Controller Select";
            desc = "";
            hw   = rw;
            sw   = rw;
        } ACR_FSM_OP_SELECT[2:2];
        field {
            name = "Handoff Delay NACK";
            desc = "";
            hw   = rw;
            sw   = rw;
        } HANDOFF_DELAY_NACK[1:1];
        field {
            name = "Pending RX NACK";
            desc = "";
            hw   = rw;
            sw   = rw;
        } PENDING_RX_NACK[0:0];
    } STBY_CR_CONTROL;
    reg {
        name = "Standby Controller Device Address";
        desc = "";
        field {
            name = "Dynamic Address is Valid";
            desc = "";
            hw   = rw;
            sw   = rw;
        } DYNAMIC_ADDR_VALID[31:31];
        field {
            name = "Device Dynamic Address";
            desc = "";
            hw   = rw;
            sw   = rw;
        } DYNAMIC_ADDR[22:16];
        field {
            name = "Static Address is Valid";
            desc = "";
            hw   = rw;
            sw   = rw;
        } STATIC_ADDR_VALID[15:15];
        field {
            name = "Device Static Address";
            desc = "";
            hw   = rw;
            sw   = rw;
        } STATIC_ADDR[6:0];
    } STBY_CR_DEVICE_ADDR;
    reg {
        name = "Standby Controller Capabilities";
        desc = "";
        field {
            name = "DAA_ENTDAA_SUPPORT";
            desc = "";
            hw   = rw;
            sw   = rw;
        } DAA_ENTDAA_SUPPORT[15:15];
        field {
            name = "DAA_SETDASA_SUPPORT";
            desc = "";
            hw   = rw;
            sw   = rw;
        } DAA_SETDASA_SUPPORT[14:14];
        field {
            name = "DAA_SETAASA_SUPPORT";
            desc = "";
            hw   = rw;
            sw   = rw;
        } DAA_SETAASA_SUPPORT[13:13];
        field {
            name = "TARGET_XACT_SUPPORT";
            desc = "";
            hw   = rw;
            sw   = rw;
        } TARGET_XACT_SUPPORT[12:12];
        field {
            name = "SIMPLE_CRR_SUPPORT";
            desc = "";
            hw   = rw;
            sw   = rw;
        } SIMPLE_CRR_SUPPORT[5:5];
    } STBY_CR_CAPABILITIES;
    reg {
        name = "Reserved 0";
        desc = "";
        field {
            name = "Reserved";
            desc = "";
            hw   = rw;
            sw   = rw;
        } __rsvd[31:0];
    } __rsvd_0;
    reg {
        name = "Standby Controller Status";
        desc = "";
        field {
            name = "HJ_REQ_STATUS";
            desc = "";
            hw   = rw;
            sw   = rw;
        } HJ_REQ_STATUS[8:8];
        field {
            name = "SIMPLE_CRR_STATUS";
            desc = "";
            hw   = rw;
            sw   = rw;
        } SIMPLE_CRR_STATUS[7:5];
        field {
            name = "AC_CURRENT_OWN";
            desc = "";
            hw   = rw;
            sw   = rw;
        } AC_CURRENT_OWN[2:2];
    } STBY_CR_STATUS;
    reg {
        name = "Standby Controller Device Characteristics";
        desc = "";
        field {
            name = "BCR_FIXED";
            desc = "";
            hw   = rw;
            sw   = rw;
        } BCR_FIXED[31:29];
        field {
            name = "BCR_VAR";
            desc = "";
            hw   = rw;
            sw   = rw;
        } BCR_VAR[28:24];
        field {
            name = "DCR";
            desc = "";
            hw   = rw;
            sw   = rw;
        } DCR[23:16];
        field {
            name = "PID_HI";
            desc = "";
            hw   = rw;
            sw   = rw;
        } PID_HI[15:1];
    } STBY_CR_DEVICE_CHAR;
    reg {
        name = "Standby Controller Device PID Low";
        desc = "";
        field {
            name = "PID_LO";
            desc = "";
            hw   = rw;
            sw   = rw;
        } PID_LO[31:0];
    } STBY_CR_DEVICE_PID_LO;
    reg {
        name = "Standby Controller Interrupt Status";
        desc = "";
        field {
            name = "";
            desc = "";
            hw   = rw;
            sw   = rw;
        } CCC_FATAL_RSTDAA_ERR_STAT[19:19];
        field {
            name = "";
            desc = "";
            hw   = rw;
            sw   = rw;
        } CCC_UNHANDLED_NACK_STAT[18:18];
        field {
            name = "";
            desc = "";
            hw   = rw;
            sw   = rw;
        } CCC_PARAM_MODIFIED_STAT[17:17];
        field {
            name = "";
            desc = "";
            hw   = rw;
            sw   = rw;
        } STBY_CR_OP_RSTACT_STAT[16:16];
        field {
            name = "";
            desc = "";
            hw   = rw;
            sw   = rw;
        } STBY_CR_ACCEPT_ERR_STAT[14:14];
        field {
            name = "";
            desc = "";
            hw   = rw;
            sw   = rw;
        } STBY_CR_ACCEPT_OK_STAT[13:13];
        field {
            name = "";
            desc = "";
            hw   = rw;
            sw   = rw;
        } STBY_CR_ACCEPT_NACKED_STAT[12:12];
        field {
            name = "";
            desc = "";
            hw   = rw;
            sw   = rw;
        } STBY_CR_DYN_ADDR_STAT[11:11];
        field {
            name = "";
            desc = "";
            hw   = rw;
            sw   = rw;
        } CRR_RESPONSE_STAT[10:10];
        field {
            name = "";
            desc = "";
            hw   = rw;
            sw   = rw;
        } ACR_HANDOFF_ERR_M3_STAT[3:3];
        field {
            name = "";
            desc = "";
            hw   = rw;
            sw   = rw;
        } ACR_HANDOFF_ERR_FAIL_STAT[2:2];
        field {
            name = "";
            desc = "";
            hw   = rw;
            sw   = rw;
        } ACR_HANDOFF_OK_PRIMED_STAT[1:1];
        field {
            name = "";
            desc = "";
            hw   = rw;
            sw   = rw;
        } ACR_HANDOFF_OK_REMAIN_STAT[0:0];
    } STBY_CR_INTR_STATUS;
    reg {
        name = "Reserved 1";
        desc = "";
        field {
            name = "Reserved";
            desc = "";
            hw   = rw;
            sw   = rw;
        } __rsvd[31:0];
    } __rsvd_1;
    reg {
        name = "Standby Controller Interrupt Signal Enable";
        desc = "";
        field {
            name = "";
            desc = "";
            hw   = rw;
            sw   = rw;
        } CCC_FATAL_RSTDAA_ERR_SIGNAL_EN[19:19];
        field {
            name = "";
            desc = "";
            hw   = rw;
            sw   = rw;
        } CCC_UNHANDLED_NACK_SIGNAL_EN[18:18];
        field {
            name = "";
            desc = "";
            hw   = rw;
            sw   = rw;
        } CCC_PARAM_MODIFIED_SIGNAL_EN[17:17];
        field {
            name = "";
            desc = "";
            hw   = rw;
            sw   = rw;
        } STBY_CR_OP_RSTACT_SIGNAL_EN[16:16];
        field {
            name = "";
            desc = "";
            hw   = rw;
            sw   = rw;
        } STBY_CR_ACCEPT_ERR_SIGNAL_EN[14:14];
        field {
            name = "";
            desc = "";
            hw   = rw;
            sw   = rw;
        } STBY_CR_ACCEPT_OK_SIGNAL_EN[13:13];
        field {
            name = "";
            desc = "";
            hw   = rw;
            sw   = rw;
        } STBY_CR_ACCEPT_NACKED_SIGNAL_EN[12:12];
        field {
            name = "";
            desc = "";
            hw   = rw;
            sw   = rw;
        } STBY_CR_DYN_ADDR_SIGNAL_EN[11:11];
        field {
            name = "";
            desc = "";
            hw   = rw;
            sw   = rw;
        } CRR_RESPONSE_SIGNAL_EN[10:10];
        field {
            name = "";
            desc = "";
            hw   = rw;
            sw   = rw;
        } ACR_HANDOFF_ERR_M3_SIGNAL_EN[3:3];
        field {
            name = "";
            desc = "";
            hw   = rw;
            sw   = rw;
        } ACR_HANDOFF_ERR_FAIL_SIGNAL_EN[2:2];
        field {
            name = "";
            desc = "";
            hw   = rw;
            sw   = rw;
        } ACR_HANDOFF_OK_PRIMED_SIGNAL_EN [1:1];
        field {
            name = "";
            desc = "";
            hw   = rw;
            sw   = rw;
        } ACR_HANDOFF_OK_REMAIN_SIGNAL_EN[0:0];
    } STBY_CR_INTR_SIGNAL_ENABLE;
    reg {
        name = "Standby Controller Interrupt Force";
        desc = "";
        field {
            name = "";
            desc = "";
            hw   = rw;
            sw   = rw;
        } CCC_FATAL_RSTDAA_ERR_FORCE[19:19];
        field {
            name = "";
            desc = "";
            hw   = rw;
            sw   = rw;
        } CCC_UNHANDLED_NACK_FORCE[18:18];
        field {
            name = "";
            desc = "";
            hw   = rw;
            sw   = rw;
        } CCC_PARAM_MODIFIED_FORCE[17:17];
        field {
            name = "";
            desc = "";
            hw   = rw;
            sw   = rw;
        } STBY_CR_OP_RSTACT_FORCE[16:16];
        field {
            name = "";
            desc = "";
            hw   = rw;
            sw   = rw;
        } STBY_CR_ACCEPT_ERR_FORCE[14:14];
        field {
            name = "";
            desc = "";
            hw   = rw;
            sw   = rw;
        } STBY_CR_ACCEPT_OK_FORCE[13:13];
        field {
            name = "";
            desc = "";
            hw   = rw;
            sw   = rw;
        } STBY_CR_ACCEPT_NACKED_FORCE[12:12];
        field {
            name = "";
            desc = "";
            hw   = rw;
            sw   = rw;
        } STBY_CR_DYN_ADDR_FORCE[11:11];
        field {
            name = "";
            desc = "";
            hw   = rw;
            sw   = rw;
        } CRR_RESPONSE_FORCE[10:10];
    } STBY_CR_INTR_FORCE;
    reg {
        name = "Standby Controller CCC Configuration GETCAPS";
        desc = "";
        field {
            name = "";
            desc = "";
            hw   = rw;
            sw   = rw;
        } F2_CRCAP2_DEV_INTERACT[11:8];
        field {
            name = "";
            desc = "";
            hw   = rw;
            sw   = rw;
        } F2_CRCAP1_BUS_CONFIG[2:0];
    } STBY_CR_CCC_CONFIG_GETCAPS;
    reg {
        name = "Standby Controller CCC Configuration RSTACT";
        desc = "";
        field {
            name = "";
            desc = "";
            hw   = rw;
            sw   = rw;
        } RESET_DYNAMIC_ADDR[31:31];
        field {
            name = "";
            desc = "";
            hw   = rw;
            sw   = rw;
        } RESET_TIME_TARGET[23:16];
        field {
            name = "";
            desc = "";
            hw   = rw;
            sw   = rw;
        } RESET_TIME_PERIPHERAL[15:8];
        field {
            name = "";
            desc = "";
            hw   = rw;
            sw   = rw;
        } RST_ACTION[7:0];
    } STBY_CR_CCC_CONFIG_RSTACT_PARAMS;
    reg {
        name = "Reserved 2";
        desc = "";
        field {
            name = "Reserved";
            desc = "";
            hw   = rw;
            sw   = rw;
        } __rsvd[31:0];
    } __rsvd_2;
    reg {
        name = "Reserved 3";
        desc = "";
        field {
            name = "Reserved";
            desc = "";
            hw   = rw;
            sw   = rw;
        } __rsvd[31:0];
    } __rsvd_3;
};
