// I3C controller register map based on MIPI HCI 1.2


regfile TargetTransactionInterfaceRegisters{
    default regwidth = 32;
    reg {
        regwidth = 32;
        field {
            name = "CAP_LENGTH";
            desc = "Capability Structure Length in DWORDs";
            sw = r;
            hw = r;
            reset = 16'h0000;
        } CAP_LENGTH[23:8];
        field {
            name = "CAP_ID";
            desc = "Extended Capability ID";
            sw = r;
            hw = r;
            reset = 8'hC4;
        } CAP_ID[7:0];
    } EXTCAP_HEADER;
    reg {
        name = "TTI Control";
        desc = "Control Register";
        field {
            name = "";
            desc = "";
            sw = rw;
            hw = rw;
            reset = 32'h00000000;
        } PLACEHOLDER[31:0];
    } TTI_CONTROL;
    reg {
        name = "TTI Status";
        desc = "Status Register";
        field {
            name = "";
            desc = "";
            sw = rw;
            hw = rw;
            reset = 32'h00000000;
        } PLACEHOLDER[31:0];
    } TTI_STATUS;
    reg {
        name = "TTI Interrupt Status";
        desc = "Interrupt Status";
        field {
            name = "";
            desc = "";
            sw = rw;
            hw = rw;
            reset = 32'h00000000;
        } PLACEHOLDER[31:0];
    } TTI_INTERRUPT_STATUS;
    reg {
        name = "TTI Interrupt Enable";
        desc = "Interrupt Enable";
        field {
            name = "";
            desc = "";
            sw = rw;
            hw = rw;
            reset = 32'h00000000;
        } PLACEHOLDER[31:0];
    } TTI_INTERRUPT_ENABLE;
    reg {
        name = "TTI Interrupt Force";
        desc = "Interrupt Force";
        field {
            name = "";
            desc = "";
            sw = rw;
            hw = rw;
            reset = 32'h00000000;
        } PLACEHOLDER[31:0];
    } TTI_INTERRUPT_FORCE;
    reg {
        name = "TTI RX Descriptor Queue Port";
        desc = "RX Descriptor Queue Port";
        field {
            name = "TTI_RX_DESCRIPTOR";
            desc = "RX Data";
            sw = rw;
            hw = rw;
            reset = 32'h00000000;
        } TTI_RX_DESCRIPTOR[31:0];
    } TTI_RX_DESCRIPTOR_QUEUE_PORT;
    reg {
        name = "TTI RX Data Port";
        desc = "RX Data Port";
        field {
            name = "TTI_RX_DATA";
            desc = "RX Data";
            sw = rw;
            hw = rw;
            reset = 32'h00000000;
        } TTI_RX_DATA[31:0];
    } TTI_RX_DATA_PORT;
    reg {
        name = "TTI TX Descriptor Queue Port";
        desc = "TX Descriptor Queue Port";
        field {
            name = "TTI_TX_DESCRIPTOR";
            desc = "TX Data";
            sw = rw;
            hw = rw;
            reset = 32'h00000000;
        } TTI_TX_DESCRIPTOR[31:0];
    } TTI_TX_DESCRIPTOR_QUEUE_PORT;
    reg {
        name = "TTI TX Data Port";
        desc = "TX Data Port";
        field {
            name = "TTI_TX_DATA";
            desc = "TX Data";
            sw = rw;
            hw = rw;
            reset = 32'h00000000;
        } TTI_TX_DATA[31:0];
    } TTI_TX_DATA_PORT;
    reg {
        name = "TTI Queue Size";
        desc = "Queue Size";
        field {
            name = "TTI_TX_DATA_BUFFER_SIZE";
            desc = "";
            sw = r;
            hw = na;
            reset = 8'h07;
        } TTI_TX_DATA_BUFFER_SIZE[31:24];
        field {
            name = "TTI_RX_DATA_BUFFER_SIZE";
            desc = "";
            sw = r;
            hw = na;
            reset = 8'h07;
        } TTI_RX_DATA_BUFFER_SIZE[23:16];
        field {
            name = "TTI_TX_DESCRIPTOR_BUFFER_SIZE";
            desc = "";
            sw = r;
            hw = na;
            reset = 8'h07;
        } TTI_TX_DESCRIPTOR_BUFFER_SIZE[15:8];
        field {
            name = "TTI_RX_DESCRIPTOR_BUFFER_SIZE";
            desc = "";
            sw = r;
            hw = na;
            reset = 8'h07;
        } TTI_RX_DESCRIPTOR_BUFFER_SIZE[7:0];
    } TTI_QUEUE_SIZE;
    reg {
        name = "TTI Queue Threshold Control";
        desc = "Queue Threshold Control";
        field {
            name = "TTI_TX_DATA_THLD";
            desc = "";
            sw = rw;
            hw = r;
            reset = 8'h00;
        } TTI_TX_DATA_THLD[31:24];
        field {
            name = "TTI_RX_DATA_THLD";
            desc = "";
            sw = rw;
            hw = r;
            reset = 8'h00;
        } TTI_RX_DATA_THLD[23:16];
        field {
            name = "TTI_TX_DESCRIPTOR_THLD";
            desc = "";
            sw = rw;
            hw = r;
            reset = 8'h00;
        } TTI_TX_DESCRIPTOR_THLD[15:8];
        field {
            name = "TTI_RX_DESCRIPTOR_THLD";
            desc = "";
            sw = rw;
            hw = r;
            reset = 8'h00;
        } TTI_RX_DESCRIPTOR_THLD[7:0];
    } TTI_QUEUE_THRESHOLD_CONTROL;

};
