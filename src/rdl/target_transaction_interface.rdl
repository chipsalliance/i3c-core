// I3C controller register map based on MIPI HCI 1.2


regfile TargetTransactionInterfaceRegisters #(
    bit rx_desc_fifo_size,
    bit tx_desc_fifo_size,
    bit rx_fifo_size,
    bit tx_fifo_size
){
    name = "Target Transaction Interface";
    default regwidth = 32;
    reg {
        regwidth = 32;
        field {
            name = "CAP_LENGTH";
            desc = "Capability Structure Length in DWORDs";
            sw = r;
            hw = r;
            reset = 16'h0000;
        } CAP_LENGTH[23:8];
        field {
            name = "CAP_ID";
            desc = "Extended Capability ID";
            sw = r;
            hw = r;
            reset = 8'hC4;
        } CAP_ID[7:0];
    } EXTCAP_HEADER;
    reg {
        name = "TTI Control";
        desc = "Control Register";
        field {
            name = "";
            desc = "";
            sw = rw;
            hw = rw;
            reset = 32'h00000000;
        } PLACEHOLDER[31:0];
    } CONTROL;
    reg {
        name = "TTI Status";
        desc = "Status Register";
        field {
            name = "";
            desc = "";
            sw = rw;
            hw = rw;
            reset = 32'h00000000;
        } PLACEHOLDER[31:0];
    } STATUS;
    reg {
        name = "TTI Interrupt Status";
        desc = "Interrupt Status";
        field {
            name = "";
            desc = "";
            sw = rw;
            hw = rw;
            reset = 32'h00000000;
        } PLACEHOLDER[31:0];
    } INTERRUPT_STATUS;
    reg {
        name = "TTI Interrupt Enable";
        desc = "Interrupt Enable";
        field {
            name = "";
            desc = "";
            sw = rw;
            hw = rw;
            reset = 32'h00000000;
        } PLACEHOLDER[31:0];
    } INTERRUPT_ENABLE;
    reg {
        name = "TTI Interrupt Force";
        desc = "Interrupt Force";
        field {
            name = "";
            desc = "";
            sw = rw;
            hw = rw;
            reset = 32'h00000000;
        } PLACEHOLDER[31:0];
    } INTERRUPT_FORCE;
    external reg {
        name = "TTI RX Descriptor Queue Port";
        desc = "RX Descriptor Queue Port";
        field {
            name = "RX_DESC";
            desc = "RX Data";
            sw = r;
            hw = w;
            reset = 32'h00000000;
        } RX_DESC[31:0];
    } RX_DESC_QUEUE_PORT;
    external reg {
        name = "TTI RX Data Port";
        desc = "RX Data Port";
        field {
            name = "RX_DATA";
            desc = "RX Data";
            sw = r;
            hw = w;
            reset = 32'h00000000;
        } RX_DATA[31:0];
    } RX_DATA_PORT;
    external reg {
        name = "TTI TX Descriptor Queue Port";
        desc = "TX Descriptor Queue Port";
        field {
            name = "TX_DESC";
            desc = "TX Data";
            sw = w;
            hw = r;
            reset = 32'h00000000;
        } TX_DESC[31:0];
    } TX_DESC_QUEUE_PORT;
    external reg {
        name = "TTI TX Data Port";
        desc = "TX Data Port";
        field {
            name = "TX_DATA";
            desc = "TX Data";
            sw = w;
            hw = r;
            reset = 32'h00000000;
        } TX_DATA[31:0];
    } TX_DATA_PORT;
    reg {
        name = "TTI Queue Size";
        desc = "Queue Size";
        field {
            name = "TX_DATA_BUFFER_SIZE";
            desc = "";
            sw = r;
            hw = na;
            reset = tx_fifo_size;
        } TX_DATA_BUFFER_SIZE[31:24];
        field {
            name = "RX_DATA_BUFFER_SIZE";
            desc = "";
            sw = r;
            hw = na;
            reset = rx_fifo_size;
        } RX_DATA_BUFFER_SIZE[23:16];
        field {
            name = "TX_DESC_BUFFER_SIZE";
            desc = "";
            sw = r;
            hw = na;
            reset = tx_desc_fifo_size;
        } TX_DESC_BUFFER_SIZE[15:8];
        field {
            name = "RX_DESC_BUFFER_SIZE";
            desc = "";
            sw = r;
            hw = na;
            reset = rx_desc_fifo_size;
        } RX_DESC_BUFFER_SIZE[7:0];
    } QUEUE_SIZE;
    reg {
        name = "TTI Queue Threshold Control";
        desc = "Queue Threshold Control";
        field {
            name = "TX_DATA_THLD";
            desc = "";
            sw = rw;
            hw = r;
            reset = 8'h00;
        } TX_DATA_THLD[31:24];
        field {
            name = "RX_DATA_THLD";
            desc = "";
            sw = rw;
            hw = r;
            reset = 8'h00;
        } RX_DATA_THLD[23:16];
        field {
            name = "TX_DESC_THLD";
            desc = "";
            sw = rw;
            hw = r;
            reset = 8'h00;
        } TX_DESC_THLD[15:8];
        field {
            name = "RX_DESC_THLD";
            desc = "";
            sw = rw;
            hw = r;
            reset = 8'h00;
        } RX_DESC_THLD[7:0];
    } QUEUE_THRESHOLD_CONTROL;

};
