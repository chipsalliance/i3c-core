reg DCT_structure {
    regwidth = 128;
    field {
        name = "DYNAMIC_ADDRESS";
        desc = "Device I3C Dynamic Address after ENTDAA";
        sw = r;
        hw = rw;
    } dynamic_addr [103:96];
    field {
        name = "BCR";
        desc = "Value of the I3C device's Bus Characteristics Register";
        sw = r;
        hw = rw;
    } bcr [79:72];
    field {
        name = "DCR";
        desc = "Value of the I3C device's Device Characteristics Register";
        sw = r;
        hw = rw;
    } dcr [71:64];
    field {
        name = "PID_LO";
        desc = "Device Provisional ID Low";
        sw = r;
        hw = rw;
    } pid_lo [47:32];
    field {
        name = "PID_HI";
        desc = "Device Provisional ID High";
        sw = r;
        hw = rw;
    } pid_hi [31:0];
};
