reg DAT_structure {
    regwidth = 64;
    field {
        name = "AUTOCMD_HDR_CODE";
        desc = "Device auto command in HDR mode";
        sw = rw;
        hw = r;
    } autocmd_hdr [58:51];
    field {
        name = "AUTOCMD_MODE";
        desc = "Auto command mode and speed";
        sw = rw;
        hw = r;
    } autocmd_mode [50:48];
    field {
        name = "AUTOCMD_VALUE";
        desc = "IBI value that triggers auto command";
        sw = rw;
        hw = r;
    } autocmd_val [47:40];
    field {
        name = "AUTOCMD_MASK";
        desc = "IBI mask";
        sw = rw;
        hw = r;
    } autocmd_mask [39:32];
    field {
        name = "DEVICE";
        desc = "Device type:
            0 - I3C device,
            1 - I2C device.";
        sw = rw;
        hw = r;
    } dev [31:31];
    field {
        name = "DEV_NACK_RETRY_CNT";
        desc = "Number of retries before giving up";
        sw = rw;
        hw = r;
    } retry_cnt [30:29];
    field {
        name = "RING_ID";
        desc = "Send IBI read to ring bundle";
        sw = rw;
        hw = r;
    } ring_id [28:26];
    field {
        name = "DYNAMIC_ADDRESS";
        desc = "I3C dynamic address";
        sw = rw;
        hw = rw;
    } dynamic_adr [23:16];
    field {
        name = "TS";
        desc = "Enable/disable IBI timestamp";
        sw = rw;
        hw =r;
    } ts [15:15];
    field {
        name = "CRR_REJECT";
        desc = "Reject device's request for controller change";
        sw = rw;
        hw = r;
    } crr_reject [14:14];
    field {
        name = "IBI_REJECT";
        desc = "Reject device's request for IBI";
        sw = rw;
        hw = r;
    } ibi_reject [13:13];
    field {
        name = "IBI_PAYLOAD";
        desc = "Device's IBI contains data payload";
        sw = rw;
        hw = r;
    } ibi_payload [12:12];
    field {
        name = "STATIC_ADDRESS";
        desc = "I3C/I2C static device address";
        sw = rw;
        hw = r;
    } static_addr[6:0];
};

